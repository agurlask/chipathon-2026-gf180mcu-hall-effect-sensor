** sch_path: /foss/designs/chipathon-2026-gf180mcu-hall-effect-sensor/xschem/ccia_top_level/ccia_top_level.sch
**.subckt ccia_top_level
x1 net2 vdd vs1_p net1 vvg_n vss vs1_n vs2_p vcm vout_n vs2_n vout_p ccia_main_ota
x2 phi1 vss vs1_n phi2 vs1_p phi1_n phi2_n vs2_p vs2_n vdd chopper
I0 vdd net1 10u
V1 vcm vss 1.65
C1 voutchop_p vvg_n 100f
C2 voutchop_n net2 100f
x3 phi1 vss voutchop_p phi2 voutchop_n phi1_n phi2_n vout_p vout_n vdd chopper
x4 phi1 vss vin_p phi2 vin_n phi1_n phi2_n vinchop_p vinchop_n vdd chopper
C3 vvg_p vinchop_p 10p
C4 vvg_n vinchop_n 10p
C5 vout_n vcm 10p
C6 vout_p vcm 10p
E1 vin_p net3 vin vss 0.5
E2 vin_n net3 vin vss -0.5
Vin vin vss DC {vd} AC 1 0
V6 phi1 vss PULSE(0 3.3 0 500p 500p {tper/2-tdead-500p} {tper})
V2 phi1_n vss PULSE(3.3 0 0 500p 500p {tper/2-tdead-500p} {tper})
V8 phi2 vss PULSE(0 3.3 {tper/2} 500p 500p {tper/2-tdead-500p} {tper})
V9 phi2_n vss PULSE(3.3 0 {tper/2} 500p 500p {tper/2-tdead-500p} {tper})
V4 vdd vss 3.3
V5 vss 0 0
R1 vvg_p net4 1G
R2 vvg_n net4 1G
V3 net4 vss 0.5
V7 net3 vss 0.5
V10 net2 vvg_p 10m
x5 vvg_rrl_p vvg_rrl_n vint_n vint_p vdd vss vcm net5 telescopic
C7 vout_p vrrl_p 100f
C8 vout_n vrrl_n 100f
x7 phi1 vss vvg_rrl_p phi2 vvg_rrl_n phi1_n phi2_n vrrl_p vrrl_n vdd chopper
C9 vvg_rrl_p vint_p 2p
C10 vvg_rrl_n vint_n 2p
x6 vint_p vint_n vs1_p vs1_n vdd vss net6 telescopic_no_cmfb
I1 net6 vss 10u
I2 net5 vss 10u
R3 vvg_rrl_p net7 1G
R4 vvg_rrl_n net7 1G
V11 net7 vss 0.5
**** begin user architecture code

.options method=gear
.param tper=100u
.param tdead=1n
.param vd=0.002
.ic v(vout_p)=1.65 v(vout_n)=1.65
.ic v(vs2_p)=0.76 v(vs2_n)=0.76
.ic v(vinchop_p)=0.5 v(vinchop_n)=0.5
.control
	tran 5n 1000u
	let vdiff = v(vout_p)-v(vout_n)
        meas tran vavg AVG vdiff
.endc

.include /foss/pdks/gf180mcuD/libs.tech/ngspice/design.ngspice
.lib /foss/pdks/gf180mcuD/libs.tech/ngspice/sm141064.ngspice typical

**** end user architecture code
**.ends

* expanding   symbol:  ccia_top_level/ccia_main_ota.sym # of pins=12
** sym_path: /foss/designs/chipathon-2026-gf180mcu-hall-effect-sensor/xschem/ccia_top_level/ccia_main_ota.sym
** sch_path: /foss/designs/chipathon-2026-gf180mcu-hall-effect-sensor/xschem/ccia_top_level/ccia_main_ota.sch
.subckt ccia_main_ota vin_p vdd s1_p iref vin_n vss s1_n s2_p vcm_set vout_p s2_n vout_n
*.iopin vin_p
*.iopin vin_n
*.iopin vout_p
*.iopin vout_n
*.iopin iref
*.iopin vdd
*.iopin vss
*.iopin vcm_set
*.iopin s1_p
*.iopin s1_n
*.iopin s2_p
*.iopin s2_n
x1 vint_n vint_p vin_p vin_n s1_icmfb s1_input_pair
x2 vdd s1_icmfb s1_n s1_p vgs_gen vds_gen iref_copy s1_pmos_bias
x3 iref iref_copy vint_n vint_p vss vtail s1_nmos_bias
x4 s1_n s1_p vint_n vint_p vgs_gen vds_gen vss s1_nmos_casc
x5 s1_icmfb s1_p s1_n vss s1_cmfb
x6 vout_p vout_n vcm_set vtail s2_vcmfb vdd vss s2_cmfb
x7 s2_vcmfb vdd vss s2_p vout_n s2_half_circuit
x8 s2_vcmfb vdd vss s2_n vout_p s2_half_circuit
.ends

* expanding   symbol:  chopper/chopper.sym # of pins=10
** sym_path: /foss/designs/chipathon-2026-gf180mcu-hall-effect-sensor/xschem/chopper/chopper.sym
** sch_path: /foss/designs/chipathon-2026-gf180mcu-hall-effect-sensor/xschem/chopper/chopper.sch
.subckt chopper phi1 vss vin_p phi2 vin_n phi1_n phi2_n vout_p vout_n vdd
*.iopin vss
*.iopin vin_p
*.iopin vin_n
*.iopin vout_p
*.iopin vout_n
*.ipin phi1
*.ipin phi2
*.ipin phi1_n
*.ipin phi2_n
*.iopin vdd
x1 vdd vin_p vss vout_p phi1_n phi1 tgate
x2 vdd vin_p vss vout_n phi2_n phi2 tgate
x3 vdd vin_n vss vout_p phi2_n phi2 tgate
x4 vdd vin_n vss vout_n phi1_n phi1 tgate
.ends

* expanding   symbol:  rrl/telescopic.sym # of pins=8
** sym_path: /foss/designs/chipathon-2026-gf180mcu-hall-effect-sensor/xschem/rrl/telescopic.sym
** sch_path: /foss/designs/chipathon-2026-gf180mcu-hall-effect-sensor/xschem/rrl/telescopic.sch
.subckt telescopic vin_p vin_n vout_p vout_n vdd vss vcm_set iref
*.iopin vin_p
*.iopin vin_n
*.iopin vout_p
*.iopin vout_n
*.iopin vdd
*.iopin vss
*.iopin vcm_set
*.iopin iref
x1 vtail vdd vin_n vin_p vps_1 vps_2 telescopic_input_pair
x2 vdd vss vps_1 vps_2 vns_1 vns_2 vout_p vout_n vbp vbn telescopic_cascode
x3 vbn v_pcasc_bias vtail vbp vss vdd telescopic_cascode_bias
x4 vdd vbn v_pcasc_bias vtail iref telescopic_pmos_bias
x5 vns_1 vns_2 vout_p vout_n iref vdd vss vcm_set telescopic_cmfb
.ends

* expanding   symbol:  rrl/telescopic_no_cmfb.sym # of pins=7
** sym_path: /foss/designs/chipathon-2026-gf180mcu-hall-effect-sensor/xschem/rrl/telescopic_no_cmfb.sym
** sch_path: /foss/designs/chipathon-2026-gf180mcu-hall-effect-sensor/xschem/rrl/telescopic_no_cmfb.sch
.subckt telescopic_no_cmfb vin_p vin_n vout_p vout_n vdd vss iref
*.iopin vin_p
*.iopin vin_n
*.iopin vout_p
*.iopin vout_n
*.iopin vdd
*.iopin vss
*.iopin iref
x1 vtail vdd vin_n vin_p vps_1 vps_2 telescopic_input_pair
x2 vdd vss vps_1 vps_2 vns_1 vns_2 vout_p vout_n vbp vbn telescopic_cascode
x3 vbn v_pcasc_bias vtail vbp vss vdd telescopic_cascode_bias
x4 vdd vbn v_pcasc_bias vtail iref telescopic_pmos_bias
XM16 vg_nmos iref vdd vdd pfet_03v3 L=3u W=4u nf=1 ad='int((nf+1)/2) * W/nf * 0.18u' as='int((nf+2)/2) * W/nf * 0.18u' pd='2*int((nf+1)/2) * (W/nf + 0.18u)'
+ ps='2*int((nf+2)/2) * (W/nf + 0.18u)' nrd='0.18u / W' nrs='0.18u / W' sa=0 sb=0 sd=0 m=20
XM12 vns_1 vg_nmos vss vss nfet_03v3 L=3u W=18u nf=4 ad='int((nf+1)/2) * W/nf * 0.18u' as='int((nf+2)/2) * W/nf * 0.18u' pd='2*int((nf+1)/2) * (W/nf + 0.18u)'
+ ps='2*int((nf+2)/2) * (W/nf + 0.18u)' nrd='0.18u / W' nrs='0.18u / W' sa=0 sb=0 sd=0
XM25 vg_nmos vg_nmos vss vss nfet_03v3 L=3u W=18u nf=4 ad='int((nf+1)/2) * W/nf * 0.18u' as='int((nf+2)/2) * W/nf * 0.18u' pd='2*int((nf+1)/2) * (W/nf + 0.18u)'
+ ps='2*int((nf+2)/2) * (W/nf + 0.18u)' nrd='0.18u / W' nrs='0.18u / W' sa=0 sb=0 sd=0
XM1 vns_2 vg_nmos vss vss nfet_03v3 L=3u W=18u nf=4 ad='int((nf+1)/2) * W/nf * 0.18u' as='int((nf+2)/2) * W/nf * 0.18u' pd='2*int((nf+1)/2) * (W/nf + 0.18u)'
+ ps='2*int((nf+2)/2) * (W/nf + 0.18u)' nrd='0.18u / W' nrs='0.18u / W' sa=0 sb=0 sd=0
.ends

* expanding   symbol:  ota/s1_input_pair.sym # of pins=5
** sym_path: /foss/designs/chipathon-2026-gf180mcu-hall-effect-sensor/xschem/ota/s1_input_pair.sym
** sch_path: /foss/designs/chipathon-2026-gf180mcu-hall-effect-sensor/xschem/ota/s1_input_pair.sch
.subckt s1_input_pair vd_1 vd_2 vin_1 vin_2 vtail
*.iopin vd_1
*.iopin vd_2
*.iopin vin_1
*.iopin vin_2
*.iopin vtail
XM2 vd_1 vin_1 vtail vtail pfet_03v3 L=0.84u W=70u nf=10 ad='int((nf+1)/2) * W/nf * 0.18u' as='int((nf+2)/2) * W/nf * 0.18u' pd='2*int((nf+1)/2) * (W/nf + 0.18u)'
+ ps='2*int((nf+2)/2) * (W/nf + 0.18u)' nrd='0.18u / W' nrs='0.18u / W' sa=0 sb=0 sd=0 m=10
XM1 vd_2 vin_2 vtail vtail pfet_03v3 L=0.84u W=70u nf=10 ad='int((nf+1)/2) * W/nf * 0.18u' as='int((nf+2)/2) * W/nf * 0.18u' pd='2*int((nf+1)/2) * (W/nf + 0.18u)'
+ ps='2*int((nf+2)/2) * (W/nf + 0.18u)' nrd='0.18u / W' nrs='0.18u / W' sa=0 sb=0 sd=0 m=10
* noconn vtail
.ends

* expanding   symbol:  ota/s1_pmos_bias.sym # of pins=7
** sym_path: /foss/designs/chipathon-2026-gf180mcu-hall-effect-sensor/xschem/ota/s1_pmos_bias.sym
** sch_path: /foss/designs/chipathon-2026-gf180mcu-hall-effect-sensor/xschem/ota/s1_pmos_bias.sch
.subckt s1_pmos_bias vdd vtail vout_1 vout_2 vgscasc_gen vdsat_gen iref_copy
*.iopin vdd
*.iopin vtail
*.iopin vout_1
*.iopin vout_2
*.iopin vgscasc_gen
*.iopin vdsat_gen
*.iopin iref_copy
XM1 vt_int vr_int vdd vdd pfet_03v3 L=1.68u W=3.72u nf=1 ad='int((nf+1)/2) * W/nf * 0.18u' as='int((nf+2)/2) * W/nf * 0.18u' pd='2*int((nf+1)/2) * (W/nf + 0.18u)'
+ ps='2*int((nf+2)/2) * (W/nf + 0.18u)' nrd='0.18u / W' nrs='0.18u / W' sa=0 sb=0 sd=0 m=70
XM7 vout_2 iref_copy vo2_int vdd pfet_03v3 L=0.28u W=4u nf=1 ad='int((nf+1)/2) * W/nf * 0.18u' as='int((nf+2)/2) * W/nf * 0.18u' pd='2*int((nf+1)/2) * (W/nf + 0.18u)'
+ ps='2*int((nf+2)/2) * (W/nf + 0.18u)' nrd='0.18u / W' nrs='0.18u / W' sa=0 sb=0 sd=0 m=12
XM17 iref_copy iref_copy vr_int vdd pfet_03v3 L=0.28u W=4u nf=1 ad='int((nf+1)/2) * W/nf * 0.18u' as='int((nf+2)/2) * W/nf * 0.18u'
+ pd='2*int((nf+1)/2) * (W/nf + 0.18u)' ps='2*int((nf+2)/2) * (W/nf + 0.18u)' nrd='0.18u / W' nrs='0.18u / W' sa=0 sb=0 sd=0 m=2
XM18 vr_int vr_int vdd vdd pfet_03v3 L=1.68u W=3.72u nf=1 ad='int((nf+1)/2) * W/nf * 0.18u' as='int((nf+2)/2) * W/nf * 0.18u' pd='2*int((nf+1)/2) * (W/nf + 0.18u)'
+ ps='2*int((nf+2)/2) * (W/nf + 0.18u)' nrd='0.18u / W' nrs='0.18u / W' sa=0 sb=0 sd=0 m=5
XM4 vo1_int vr_int vdd vdd pfet_03v3 L=1.68u W=3.72u nf=1 ad='int((nf+1)/2) * W/nf * 0.18u' as='int((nf+2)/2) * W/nf * 0.18u' pd='2*int((nf+1)/2) * (W/nf + 0.18u)'
+ ps='2*int((nf+2)/2) * (W/nf + 0.18u)' nrd='0.18u / W' nrs='0.18u / W' sa=0 sb=0 sd=0 m=30
XM16 vsg_int vr_int vdd vdd pfet_03v3 L=1.68u W=3.72u nf=1 ad='int((nf+1)/2) * W/nf * 0.18u' as='int((nf+2)/2) * W/nf * 0.18u' pd='2*int((nf+1)/2) * (W/nf + 0.18u)'
+ ps='2*int((nf+2)/2) * (W/nf + 0.18u)' nrd='0.18u / W' nrs='0.18u / W' sa=0 sb=0 sd=0
XM19 vcg_int vr_int vdd vdd pfet_03v3 L=1.68u W=3.72u nf=1 ad='int((nf+1)/2) * W/nf * 0.18u' as='int((nf+2)/2) * W/nf * 0.18u' pd='2*int((nf+1)/2) * (W/nf + 0.18u)'
+ ps='2*int((nf+2)/2) * (W/nf + 0.18u)' nrd='0.18u / W' nrs='0.18u / W' sa=0 sb=0 sd=0 m=9
XM11 vo2_int vr_int vdd vdd pfet_03v3 L=1.68u W=3.72u nf=1 ad='int((nf+1)/2) * W/nf * 0.18u' as='int((nf+2)/2) * W/nf * 0.18u' pd='2*int((nf+1)/2) * (W/nf + 0.18u)'
+ ps='2*int((nf+2)/2) * (W/nf + 0.18u)' nrd='0.18u / W' nrs='0.18u / W' sa=0 sb=0 sd=0 m=30
XM6 vout_1 iref_copy vo1_int vdd pfet_03v3 L=0.28u W=4u nf=1 ad='int((nf+1)/2) * W/nf * 0.18u' as='int((nf+2)/2) * W/nf * 0.18u' pd='2*int((nf+1)/2) * (W/nf + 0.18u)'
+ ps='2*int((nf+2)/2) * (W/nf + 0.18u)' nrd='0.18u / W' nrs='0.18u / W' sa=0 sb=0 sd=0 m=12
XM25 vdsat_gen iref_copy vsg_int vdd pfet_03v3 L=0.28u W=1.6u nf=1 ad='int((nf+1)/2) * W/nf * 0.18u' as='int((nf+2)/2) * W/nf * 0.18u'
+ pd='2*int((nf+1)/2) * (W/nf + 0.18u)' ps='2*int((nf+2)/2) * (W/nf + 0.18u)' nrd='0.18u / W' nrs='0.18u / W' sa=0 sb=0 sd=0
XM26 vgscasc_gen iref_copy vcg_int vdd pfet_03v3 L=0.28u W=1.6u nf=1 ad='int((nf+1)/2) * W/nf * 0.18u' as='int((nf+2)/2) * W/nf * 0.18u'
+ pd='2*int((nf+1)/2) * (W/nf + 0.18u)' ps='2*int((nf+2)/2) * (W/nf + 0.18u)' nrd='0.18u / W' nrs='0.18u / W' sa=0 sb=0 sd=0 m=9
XM27 vtail iref_copy vt_int vdd pfet_03v3 L=0.28u W=4u nf=1 ad='int((nf+1)/2) * W/nf * 0.18u' as='int((nf+2)/2) * W/nf * 0.18u' pd='2*int((nf+1)/2) * (W/nf + 0.18u)'
+ ps='2*int((nf+2)/2) * (W/nf + 0.18u)' nrd='0.18u / W' nrs='0.18u / W' sa=0 sb=0 sd=0 m=28
.ends

* expanding   symbol:  ota/s1_nmos_bias.sym # of pins=6
** sym_path: /foss/designs/chipathon-2026-gf180mcu-hall-effect-sensor/xschem/ota/s1_nmos_bias.sym
** sch_path: /foss/designs/chipathon-2026-gf180mcu-hall-effect-sensor/xschem/ota/s1_nmos_bias.sch
.subckt s1_nmos_bias iref iref_copy vd_1 vd_2 vss vref
*.iopin iref
*.iopin iref_copy
*.iopin vd_1
*.iopin vd_2
*.iopin vss
*.iopin vref
XM14 irc_int vref vss vss nfet_03v3 L=3u W=5u nf=1 ad='int((nf+1)/2) * W/nf * 0.18u' as='int((nf+2)/2) * W/nf * 0.18u' pd='2*int((nf+1)/2) * (W/nf + 0.18u)'
+ ps='2*int((nf+2)/2) * (W/nf + 0.18u)' nrd='0.18u / W' nrs='0.18u / W' sa=0 sb=0 sd=0 m=2
XM15 vref vref vss vss nfet_03v3 L=3u W=5u nf=1 ad='int((nf+1)/2) * W/nf * 0.18u' as='int((nf+2)/2) * W/nf * 0.18u' pd='2*int((nf+1)/2) * (W/nf + 0.18u)'
+ ps='2*int((nf+2)/2) * (W/nf + 0.18u)' nrd='0.18u / W' nrs='0.18u / W' sa=0 sb=0 sd=0 m=2
XM10 vd_1 vref vss vss nfet_03v3 L=3u W=5u nf=1 ad='int((nf+1)/2) * W/nf * 0.18u' as='int((nf+2)/2) * W/nf * 0.18u' pd='2*int((nf+1)/2) * (W/nf + 0.18u)'
+ ps='2*int((nf+2)/2) * (W/nf + 0.18u)' nrd='0.18u / W' nrs='0.18u / W' sa=0 sb=0 sd=0 m=24
XM5 vd_2 vref vss vss nfet_03v3 L=3u W=5u nf=1 ad='int((nf+1)/2) * W/nf * 0.18u' as='int((nf+2)/2) * W/nf * 0.18u' pd='2*int((nf+1)/2) * (W/nf + 0.18u)'
+ ps='2*int((nf+2)/2) * (W/nf + 0.18u)' nrd='0.18u / W' nrs='0.18u / W' sa=0 sb=0 sd=0 m=24
XM23 iref iref vref vss nfet_03v3 L=3u W=5u nf=1 ad='int((nf+1)/2) * W/nf * 0.18u' as='int((nf+2)/2) * W/nf * 0.18u' pd='2*int((nf+1)/2) * (W/nf + 0.18u)'
+ ps='2*int((nf+2)/2) * (W/nf + 0.18u)' nrd='0.18u / W' nrs='0.18u / W' sa=0 sb=0 sd=0 m=2
XM24 iref_copy iref irc_int vss nfet_03v3 L=3u W=5u nf=1 ad='int((nf+1)/2) * W/nf * 0.18u' as='int((nf+2)/2) * W/nf * 0.18u' pd='2*int((nf+1)/2) * (W/nf + 0.18u)'
+ ps='2*int((nf+2)/2) * (W/nf + 0.18u)' nrd='0.18u / W' nrs='0.18u / W' sa=0 sb=0 sd=0 m=2
.ends

* expanding   symbol:  ota/s1_nmos_casc.sym # of pins=7
** sym_path: /foss/designs/chipathon-2026-gf180mcu-hall-effect-sensor/xschem/ota/s1_nmos_casc.sym
** sch_path: /foss/designs/chipathon-2026-gf180mcu-hall-effect-sensor/xschem/ota/s1_nmos_casc.sch
.subckt s1_nmos_casc vout_1 vout_2 vd_1 vd_2 vgscasc_gen vdsat_gen vss
*.iopin vout_1
*.iopin vout_2
*.iopin vd_1
*.iopin vd_2
*.iopin vgscasc_gen
*.iopin vdsat_gen
*.iopin vss
XM9 vout_2 vgscasc_gen vd_2 vss nfet_03v3 L=0.28u W=1.8u nf=1 ad='int((nf+1)/2) * W/nf * 0.18u' as='int((nf+2)/2) * W/nf * 0.18u' pd='2*int((nf+1)/2) * (W/nf + 0.18u)'
+ ps='2*int((nf+2)/2) * (W/nf + 0.18u)' nrd='0.18u / W' nrs='0.18u / W' sa=0 sb=0 sd=0 m=10
XM22 vgscasc_gen vgscasc_gen net1 vss nfet_03v3 L=0.28u W=1.8u nf=1 ad='int((nf+1)/2) * W/nf * 0.18u' as='int((nf+2)/2) * W/nf * 0.18u'
+ pd='2*int((nf+1)/2) * (W/nf + 0.18u)' ps='2*int((nf+2)/2) * (W/nf + 0.18u)' nrd='0.18u / W' nrs='0.18u / W' sa=0 sb=0 sd=0 m=3
XM21 net1 vdsat_gen vss vss nfet_03v3 L=3u W=5u nf=1 ad='int((nf+1)/2) * W/nf * 0.18u' as='int((nf+2)/2) * W/nf * 0.18u' pd='2*int((nf+1)/2) * (W/nf + 0.18u)'
+ ps='2*int((nf+2)/2) * (W/nf + 0.18u)' nrd='0.18u / W' nrs='0.18u / W' sa=0 sb=0 sd=0
XM8 vout_1 vgscasc_gen vd_1 vss nfet_03v3 L=0.28u W=1.8u nf=1 ad='int((nf+1)/2) * W/nf * 0.18u' as='int((nf+2)/2) * W/nf * 0.18u' pd='2*int((nf+1)/2) * (W/nf + 0.18u)'
+ ps='2*int((nf+2)/2) * (W/nf + 0.18u)' nrd='0.18u / W' nrs='0.18u / W' sa=0 sb=0 sd=0 m=10
XM20 vdsat_gen vdsat_gen net1 vss nfet_03v3 L=0.28u W=0.6u nf=1 ad='int((nf+1)/2) * W/nf * 0.18u' as='int((nf+2)/2) * W/nf * 0.18u'
+ pd='2*int((nf+1)/2) * (W/nf + 0.18u)' ps='2*int((nf+2)/2) * (W/nf + 0.18u)' nrd='0.18u / W' nrs='0.18u / W' sa=0 sb=0 sd=0
.ends

* expanding   symbol:  ota/s1_cmfb.sym # of pins=4
** sym_path: /foss/designs/chipathon-2026-gf180mcu-hall-effect-sensor/xschem/ota/s1_cmfb.sym
** sch_path: /foss/designs/chipathon-2026-gf180mcu-hall-effect-sensor/xschem/ota/s1_cmfb.sch
.subckt s1_cmfb icmfb s1_p s1_n vss
*.iopin icmfb
*.iopin s1_p
*.iopin s1_n
*.iopin vss
XM1 icmfb s1_p vss vss nfet_03v3 L=0.6u W=7.4u nf=2 ad='int((nf+1)/2) * W/nf * 0.18u' as='int((nf+2)/2) * W/nf * 0.18u' pd='2*int((nf+1)/2) * (W/nf + 0.18u)'
+ ps='2*int((nf+2)/2) * (W/nf + 0.18u)' nrd='0.18u / W' nrs='0.18u / W' sa=0 sb=0 sd=0
XM2 icmfb s1_n vss vss nfet_03v3 L=0.6u W=7.4u nf=2 ad='int((nf+1)/2) * W/nf * 0.18u' as='int((nf+2)/2) * W/nf * 0.18u' pd='2*int((nf+1)/2) * (W/nf + 0.18u)'
+ ps='2*int((nf+2)/2) * (W/nf + 0.18u)' nrd='0.18u / W' nrs='0.18u / W' sa=0 sb=0 sd=0
.ends

* expanding   symbol:  ota/s2_cmfb.sym # of pins=7
** sym_path: /foss/designs/chipathon-2026-gf180mcu-hall-effect-sensor/xschem/ota/s2_cmfb.sym
** sch_path: /foss/designs/chipathon-2026-gf180mcu-hall-effect-sensor/xschem/ota/s2_cmfb.sch
.subckt s2_cmfb vin_1 vin_2 vcm_set vtail_ref vcmfb vdd vss
*.iopin vin_1
*.iopin vin_2
*.iopin vcm_set
*.iopin vtail_ref
*.iopin vcmfb
*.iopin vdd
*.iopin vss
XM15 vtail_1 vtail_ref vss vss nfet_03v3 L=3u W=5u nf=1 ad='int((nf+1)/2) * W/nf * 0.18u' as='int((nf+2)/2) * W/nf * 0.18u' pd='2*int((nf+1)/2) * (W/nf + 0.18u)'
+ ps='2*int((nf+2)/2) * (W/nf + 0.18u)' nrd='0.18u / W' nrs='0.18u / W' sa=0 sb=0 sd=0 m=4
XM1 vtail_2 vtail_ref vss vss nfet_03v3 L=3u W=5u nf=1 ad='int((nf+1)/2) * W/nf * 0.18u' as='int((nf+2)/2) * W/nf * 0.18u' pd='2*int((nf+1)/2) * (W/nf + 0.18u)'
+ ps='2*int((nf+2)/2) * (W/nf + 0.18u)' nrd='0.18u / W' nrs='0.18u / W' sa=0 sb=0 sd=0 m=4
XM2 vcmfb vcmfb vdd vdd pfet_03v3 L=0.6u W=12u nf=4 ad='int((nf+1)/2) * W/nf * 0.18u' as='int((nf+2)/2) * W/nf * 0.18u' pd='2*int((nf+1)/2) * (W/nf + 0.18u)'
+ ps='2*int((nf+2)/2) * (W/nf + 0.18u)' nrd='0.18u / W' nrs='0.18u / W' sa=0 sb=0 sd=0
XM7 vint_2 vint_2 vdd vdd pfet_03v3 L=0.6u W=6u nf=2 ad='int((nf+1)/2) * W/nf * 0.18u' as='int((nf+2)/2) * W/nf * 0.18u' pd='2*int((nf+1)/2) * (W/nf + 0.18u)'
+ ps='2*int((nf+2)/2) * (W/nf + 0.18u)' nrd='0.18u / W' nrs='0.18u / W' sa=0 sb=0 sd=0
XM8 vint_1 vint_1 vdd vdd pfet_03v3 L=0.6u W=6u nf=2 ad='int((nf+1)/2) * W/nf * 0.18u' as='int((nf+2)/2) * W/nf * 0.18u' pd='2*int((nf+1)/2) * (W/nf + 0.18u)'
+ ps='2*int((nf+2)/2) * (W/nf + 0.18u)' nrd='0.18u / W' nrs='0.18u / W' sa=0 sb=0 sd=0
XM4 vcmfb vcm_set vtail_1 vss nfet_03v3 L=0.28u W=18u nf=4 ad='int((nf+1)/2) * W/nf * 0.18u' as='int((nf+2)/2) * W/nf * 0.18u' pd='2*int((nf+1)/2) * (W/nf + 0.18u)'
+ ps='2*int((nf+2)/2) * (W/nf + 0.18u)' nrd='0.18u / W' nrs='0.18u / W' sa=0 sb=0 sd=0
XM3 vint_2 vin_2 vtail_2 vss nfet_03v3 L=0.28u W=18u nf=4 ad='int((nf+1)/2) * W/nf * 0.18u' as='int((nf+2)/2) * W/nf * 0.18u' pd='2*int((nf+1)/2) * (W/nf + 0.18u)'
+ ps='2*int((nf+2)/2) * (W/nf + 0.18u)' nrd='0.18u / W' nrs='0.18u / W' sa=0 sb=0 sd=0
XM5 vcmfb vcm_set vtail_2 vss nfet_03v3 L=0.28u W=18u nf=4 ad='int((nf+1)/2) * W/nf * 0.18u' as='int((nf+2)/2) * W/nf * 0.18u' pd='2*int((nf+1)/2) * (W/nf + 0.18u)'
+ ps='2*int((nf+2)/2) * (W/nf + 0.18u)' nrd='0.18u / W' nrs='0.18u / W' sa=0 sb=0 sd=0
XM6 vint_1 vin_1 vtail_1 vss nfet_03v3 L=0.28u W=18u nf=4 ad='int((nf+1)/2) * W/nf * 0.18u' as='int((nf+2)/2) * W/nf * 0.18u' pd='2*int((nf+1)/2) * (W/nf + 0.18u)'
+ ps='2*int((nf+2)/2) * (W/nf + 0.18u)' nrd='0.18u / W' nrs='0.18u / W' sa=0 sb=0 sd=0
.ends

* expanding   symbol:  ota/s2_half_circuit.sym # of pins=5
** sym_path: /foss/designs/chipathon-2026-gf180mcu-hall-effect-sensor/xschem/ota/s2_half_circuit.sym
** sch_path: /foss/designs/chipathon-2026-gf180mcu-hall-effect-sensor/xschem/ota/s2_half_circuit.sch
.subckt s2_half_circuit vcmfb vdd vss vin vout
*.iopin vcmfb
*.iopin vdd
*.iopin vss
*.iopin vin
*.iopin vout
XM6 vout vcmfb vdd vdd pfet_03v3 L=0.6u W=12u nf=4 ad='int((nf+1)/2) * W/nf * 0.18u' as='int((nf+2)/2) * W/nf * 0.18u' pd='2*int((nf+1)/2) * (W/nf + 0.18u)'
+ ps='2*int((nf+2)/2) * (W/nf + 0.18u)' nrd='0.18u / W' nrs='0.18u / W' sa=0 sb=0 sd=0 m=7
XM1 vout vin vss vss nfet_03v3 L=0.6u W=7.4u nf=2 ad='int((nf+1)/2) * W/nf * 0.18u' as='int((nf+2)/2) * W/nf * 0.18u' pd='2*int((nf+1)/2) * (W/nf + 0.18u)'
+ ps='2*int((nf+2)/2) * (W/nf + 0.18u)' nrd='0.18u / W' nrs='0.18u / W' sa=0 sb=0 sd=0 m=14
C1 vout vin 2p
.ends

* expanding   symbol:  tgate/tgate.sym # of pins=6
** sym_path: /foss/designs/chipathon-2026-gf180mcu-hall-effect-sensor/xschem/tgate/tgate.sym
** sch_path: /foss/designs/chipathon-2026-gf180mcu-hall-effect-sensor/xschem/tgate/tgate.sch
.subckt tgate vdd va vss vb en_n en
*.iopin vdd
*.iopin vss
*.iopin en
*.iopin va
*.iopin vb
*.iopin en_n
XM1 vb en va vss nfet_03v3 L=0.28u W=3.2u nf=4 ad='int((nf+1)/2) * W/nf * 0.18u' as='int((nf+2)/2) * W/nf * 0.18u' pd='2*int((nf+1)/2) * (W/nf + 0.18u)'
+ ps='2*int((nf+2)/2) * (W/nf + 0.18u)' nrd='0.18u / W' nrs='0.18u / W' sa=0 sb=0 sd=0
XM2 va en_n vb vdd pfet_03v3 L=0.28u W=3.2u nf=4 ad='int((nf+1)/2) * W/nf * 0.18u' as='int((nf+2)/2) * W/nf * 0.18u' pd='2*int((nf+1)/2) * (W/nf + 0.18u)'
+ ps='2*int((nf+2)/2) * (W/nf + 0.18u)' nrd='0.18u / W' nrs='0.18u / W' sa=0 sb=0 sd=0
.ends

* expanding   symbol:  rrl/telescopic_input_pair.sym # of pins=6
** sym_path: /foss/designs/chipathon-2026-gf180mcu-hall-effect-sensor/xschem/rrl/telescopic_input_pair.sym
** sch_path: /foss/designs/chipathon-2026-gf180mcu-hall-effect-sensor/xschem/rrl/telescopic_input_pair.sch
.subckt telescopic_input_pair vtail vdd vin_1 vin_2 vd_1 vd_2
*.iopin vtail
*.iopin vdd
*.iopin vin_1
*.iopin vin_2
*.iopin vd_1
*.iopin vd_2
XM2 vd_1 vin_1 vtail vdd pfet_03v3 L=0.84u W=32u nf=8 ad='int((nf+1)/2) * W/nf * 0.18u' as='int((nf+2)/2) * W/nf * 0.18u' pd='2*int((nf+1)/2) * (W/nf + 0.18u)'
+ ps='2*int((nf+2)/2) * (W/nf + 0.18u)' nrd='0.18u / W' nrs='0.18u / W' sa=0 sb=0 sd=0
XM3 vd_2 vin_2 vtail vdd pfet_03v3 L=0.84u W=32u nf=8 ad='int((nf+1)/2) * W/nf * 0.18u' as='int((nf+2)/2) * W/nf * 0.18u' pd='2*int((nf+1)/2) * (W/nf + 0.18u)'
+ ps='2*int((nf+2)/2) * (W/nf + 0.18u)' nrd='0.18u / W' nrs='0.18u / W' sa=0 sb=0 sd=0
* noconn vtail
.ends

* expanding   symbol:  rrl/telescopic_cascode.sym # of pins=10
** sym_path: /foss/designs/chipathon-2026-gf180mcu-hall-effect-sensor/xschem/rrl/telescopic_cascode.sym
** sch_path: /foss/designs/chipathon-2026-gf180mcu-hall-effect-sensor/xschem/rrl/telescopic_cascode.sch
.subckt telescopic_cascode vdd vss pmos_vs_1 pmos_vs_2 nmos_vs_1 nmos_vs_2 vout_1 vout_2 pmos_vb nmos_vb
*.iopin vdd
*.iopin vss
*.iopin pmos_vs_1
*.iopin pmos_vs_2
*.iopin nmos_vs_1
*.iopin nmos_vs_2
*.iopin vout_1
*.iopin vout_2
*.iopin pmos_vb
*.iopin nmos_vb
XM10 vout_1 nmos_vb nmos_vs_1 vss nfet_03v3 L=0.28u W=6u nf=2 ad='int((nf+1)/2) * W/nf * 0.18u' as='int((nf+2)/2) * W/nf * 0.18u' pd='2*int((nf+1)/2) * (W/nf + 0.18u)'
+ ps='2*int((nf+2)/2) * (W/nf + 0.18u)' nrd='0.18u / W' nrs='0.18u / W' sa=0 sb=0 sd=0
XM11 vout_2 nmos_vb nmos_vs_2 vss nfet_03v3 L=0.28u W=6u nf=2 ad='int((nf+1)/2) * W/nf * 0.18u' as='int((nf+2)/2) * W/nf * 0.18u' pd='2*int((nf+1)/2) * (W/nf + 0.18u)'
+ ps='2*int((nf+2)/2) * (W/nf + 0.18u)' nrd='0.18u / W' nrs='0.18u / W' sa=0 sb=0 sd=0
XM7 vout_1 pmos_vb pmos_vs_1 vdd pfet_03v3 L=0.28u W=16u nf=4 ad='int((nf+1)/2) * W/nf * 0.18u' as='int((nf+2)/2) * W/nf * 0.18u' pd='2*int((nf+1)/2) * (W/nf + 0.18u)'
+ ps='2*int((nf+2)/2) * (W/nf + 0.18u)' nrd='0.18u / W' nrs='0.18u / W' sa=0 sb=0 sd=0
XM8 vout_2 pmos_vb pmos_vs_2 vdd pfet_03v3 L=0.28u W=16u nf=4 ad='int((nf+1)/2) * W/nf * 0.18u' as='int((nf+2)/2) * W/nf * 0.18u' pd='2*int((nf+1)/2) * (W/nf + 0.18u)'
+ ps='2*int((nf+2)/2) * (W/nf + 0.18u)' nrd='0.18u / W' nrs='0.18u / W' sa=0 sb=0 sd=0
.ends

* expanding   symbol:  rrl/telescopic_cascode_bias.sym # of pins=6
** sym_path: /foss/designs/chipathon-2026-gf180mcu-hall-effect-sensor/xschem/rrl/telescopic_cascode_bias.sym
** sch_path: /foss/designs/chipathon-2026-gf180mcu-hall-effect-sensor/xschem/rrl/telescopic_cascode_bias.sch
.subckt telescopic_cascode_bias vb_nmos_casc bias vtail vb_pmos_casc vss vdd
*.iopin vb_nmos_casc
*.iopin bias
*.iopin vtail
*.iopin vb_pmos_casc
*.iopin vss
*.iopin vdd
XM1 net1 vb_nmos_casc vss vss nfet_03v3 L=3u W=2u nf=1 ad='int((nf+1)/2) * W/nf * 0.18u' as='int((nf+2)/2) * W/nf * 0.18u' pd='2*int((nf+1)/2) * (W/nf + 0.18u)'
+ ps='2*int((nf+2)/2) * (W/nf + 0.18u)' nrd='0.18u / W' nrs='0.18u / W' sa=0 sb=0 sd=0
XM5 vds_input vb_pmos_casc vtail vdd pfet_03v3 L=0.84u W=8u nf=2 ad='int((nf+1)/2) * W/nf * 0.18u' as='int((nf+2)/2) * W/nf * 0.18u'
+ pd='2*int((nf+1)/2) * (W/nf + 0.18u)' ps='2*int((nf+2)/2) * (W/nf + 0.18u)' nrd='0.18u / W' nrs='0.18u / W' sa=0 sb=0 sd=0
XM15 bias bias vss vss nfet_03v3 L=3u W=4.5u nf=1 ad='int((nf+1)/2) * W/nf * 0.18u' as='int((nf+2)/2) * W/nf * 0.18u' pd='2*int((nf+1)/2) * (W/nf + 0.18u)'
+ ps='2*int((nf+2)/2) * (W/nf + 0.18u)' nrd='0.18u / W' nrs='0.18u / W' sa=0 sb=0 sd=0
XM9 vb_pmos_casc bias vss vss nfet_03v3 L=3u W=4.5u nf=1 ad='int((nf+1)/2) * W/nf * 0.18u' as='int((nf+2)/2) * W/nf * 0.18u' pd='2*int((nf+1)/2) * (W/nf + 0.18u)'
+ ps='2*int((nf+2)/2) * (W/nf + 0.18u)' nrd='0.18u / W' nrs='0.18u / W' sa=0 sb=0 sd=0
XM6 vb_pmos_casc vb_pmos_casc vds_input vdd pfet_03v3 L=0.28u W=8u nf=2 ad='int((nf+1)/2) * W/nf * 0.18u' as='int((nf+2)/2) * W/nf * 0.18u'
+ pd='2*int((nf+1)/2) * (W/nf + 0.18u)' ps='2*int((nf+2)/2) * (W/nf + 0.18u)' nrd='0.18u / W' nrs='0.18u / W' sa=0 sb=0 sd=0
XM14 vb_nmos_casc vb_nmos_casc net1 vss nfet_03v3 L=0.28u W=3u nf=1 ad='int((nf+1)/2) * W/nf * 0.18u' as='int((nf+2)/2) * W/nf * 0.18u'
+ pd='2*int((nf+1)/2) * (W/nf + 0.18u)' ps='2*int((nf+2)/2) * (W/nf + 0.18u)' nrd='0.18u / W' nrs='0.18u / W' sa=0 sb=0 sd=0
.ends

* expanding   symbol:  rrl/telescopic_pmos_bias.sym # of pins=6
** sym_path: /foss/designs/chipathon-2026-gf180mcu-hall-effect-sensor/xschem/rrl/telescopic_pmos_bias.sym
** sch_path: /foss/designs/chipathon-2026-gf180mcu-hall-effect-sensor/xschem/rrl/telescopic_pmos_bias.sch
.subckt telescopic_pmos_bias vdd vbias_ncasc vbias_pcasc vtail iref
*.iopin vdd
*.iopin vbias_ncasc
*.iopin vbias_pcasc
*.iopin vtail
*.iopin iref
XM4 vtail iref vdd vdd pfet_03v3 L=3u W=4u nf=1 ad='int((nf+1)/2) * W/nf * 0.18u' as='int((nf+2)/2) * W/nf * 0.18u' pd='2*int((nf+1)/2) * (W/nf + 0.18u)'
+ ps='2*int((nf+2)/2) * (W/nf + 0.18u)' nrd='0.18u / W' nrs='0.18u / W' sa=0 sb=0 sd=0 m=50
XM16 vbias_pcasc iref vdd vdd pfet_03v3 L=3u W=4u nf=1 ad='int((nf+1)/2) * W/nf * 0.18u' as='int((nf+2)/2) * W/nf * 0.18u' pd='2*int((nf+1)/2) * (W/nf + 0.18u)'
+ ps='2*int((nf+2)/2) * (W/nf + 0.18u)' nrd='0.18u / W' nrs='0.18u / W' sa=0 sb=0 sd=0 m=10
XM17 vbias_ncasc iref vdd vdd pfet_03v3 L=3u W=4u nf=1 ad='int((nf+1)/2) * W/nf * 0.18u' as='int((nf+2)/2) * W/nf * 0.18u' pd='2*int((nf+1)/2) * (W/nf + 0.18u)'
+ ps='2*int((nf+2)/2) * (W/nf + 0.18u)' nrd='0.18u / W' nrs='0.18u / W' sa=0 sb=0 sd=0 m=10
XM18 iref iref vdd vdd pfet_03v3 L=3u W=4u nf=1 ad='int((nf+1)/2) * W/nf * 0.18u' as='int((nf+2)/2) * W/nf * 0.18u' pd='2*int((nf+1)/2) * (W/nf + 0.18u)'
+ ps='2*int((nf+2)/2) * (W/nf + 0.18u)' nrd='0.18u / W' nrs='0.18u / W' sa=0 sb=0 sd=0 m=10
.ends

* expanding   symbol:  rrl/telescopic_cmfb.sym # of pins=8
** sym_path: /foss/designs/chipathon-2026-gf180mcu-hall-effect-sensor/xschem/rrl/telescopic_cmfb.sym
** sch_path: /foss/designs/chipathon-2026-gf180mcu-hall-effect-sensor/xschem/rrl/telescopic_cmfb.sch
.subckt telescopic_cmfb nmos_vs_1 nmos_vs_2 vout_1 vout_2 vg_pmos vdd vss vcm_set
*.iopin nmos_vs_1
*.iopin nmos_vs_2
*.iopin vout_1
*.iopin vout_2
*.iopin vg_pmos
*.iopin vdd
*.iopin vss
*.iopin vcm_set
XM12 nmos_vs_1 vb_nbias vss vss nfet_03v3 L=3u W=18u nf=4 ad='int((nf+1)/2) * W/nf * 0.18u' as='int((nf+2)/2) * W/nf * 0.18u' pd='2*int((nf+1)/2) * (W/nf + 0.18u)'
+ ps='2*int((nf+2)/2) * (W/nf + 0.18u)' nrd='0.18u / W' nrs='0.18u / W' sa=0 sb=0 sd=0
XM13 nmos_vs_2 vb_nbias vss vss nfet_03v3 L=3u W=18u nf=4 ad='int((nf+1)/2) * W/nf * 0.18u' as='int((nf+2)/2) * W/nf * 0.18u' pd='2*int((nf+1)/2) * (W/nf + 0.18u)'
+ ps='2*int((nf+2)/2) * (W/nf + 0.18u)' nrd='0.18u / W' nrs='0.18u / W' sa=0 sb=0 sd=0
XM19 vtail_cmfb1 vg_pmos vdd vdd pfet_03v3 L=3u W=4u nf=1 ad='int((nf+1)/2) * W/nf * 0.18u' as='int((nf+2)/2) * W/nf * 0.18u' pd='2*int((nf+1)/2) * (W/nf + 0.18u)'
+ ps='2*int((nf+2)/2) * (W/nf + 0.18u)' nrd='0.18u / W' nrs='0.18u / W' sa=0 sb=0 sd=0 m=20
XM22 vtail_cmfb2 vg_pmos vdd vdd pfet_03v3 L=3u W=4u nf=1 ad='int((nf+1)/2) * W/nf * 0.18u' as='int((nf+2)/2) * W/nf * 0.18u' pd='2*int((nf+1)/2) * (W/nf + 0.18u)'
+ ps='2*int((nf+2)/2) * (W/nf + 0.18u)' nrd='0.18u / W' nrs='0.18u / W' sa=0 sb=0 sd=0 m=20
XM25 vb_nbias vb_nbias vss vss nfet_03v3 L=3u W=18u nf=4 ad='int((nf+1)/2) * W/nf * 0.18u' as='int((nf+2)/2) * W/nf * 0.18u' pd='2*int((nf+1)/2) * (W/nf + 0.18u)'
+ ps='2*int((nf+2)/2) * (W/nf + 0.18u)' nrd='0.18u / W' nrs='0.18u / W' sa=0 sb=0 sd=0
XM26 vcmfb_1 vcmfb_1 vss vss nfet_03v3 L=3u W=18u nf=2 ad='int((nf+1)/2) * W/nf * 0.18u' as='int((nf+2)/2) * W/nf * 0.18u' pd='2*int((nf+1)/2) * (W/nf + 0.18u)'
+ ps='2*int((nf+2)/2) * (W/nf + 0.18u)' nrd='0.18u / W' nrs='0.18u / W' sa=0 sb=0 sd=0
XM27 vcmfb_2 vcmfb_2 vss vss nfet_03v3 L=3u W=18u nf=2 ad='int((nf+1)/2) * W/nf * 0.18u' as='int((nf+2)/2) * W/nf * 0.18u' pd='2*int((nf+1)/2) * (W/nf + 0.18u)'
+ ps='2*int((nf+2)/2) * (W/nf + 0.18u)' nrd='0.18u / W' nrs='0.18u / W' sa=0 sb=0 sd=0
XM28 vcmfb_1 vout_1 vtail_cmfb1 vdd pfet_03v3 L=0.84u W=8u nf=2 ad='int((nf+1)/2) * W/nf * 0.18u' as='int((nf+2)/2) * W/nf * 0.18u'
+ pd='2*int((nf+1)/2) * (W/nf + 0.18u)' ps='2*int((nf+2)/2) * (W/nf + 0.18u)' nrd='0.18u / W' nrs='0.18u / W' sa=0 sb=0 sd=0
XM20 vb_nbias vcm_set vtail_cmfb1 vdd pfet_03v3 L=0.84u W=8u nf=2 ad='int((nf+1)/2) * W/nf * 0.18u' as='int((nf+2)/2) * W/nf * 0.18u'
+ pd='2*int((nf+1)/2) * (W/nf + 0.18u)' ps='2*int((nf+2)/2) * (W/nf + 0.18u)' nrd='0.18u / W' nrs='0.18u / W' sa=0 sb=0 sd=0
XM21 vb_nbias vcm_set vtail_cmfb2 vdd pfet_03v3 L=0.84u W=8u nf=2 ad='int((nf+1)/2) * W/nf * 0.18u' as='int((nf+2)/2) * W/nf * 0.18u'
+ pd='2*int((nf+1)/2) * (W/nf + 0.18u)' ps='2*int((nf+2)/2) * (W/nf + 0.18u)' nrd='0.18u / W' nrs='0.18u / W' sa=0 sb=0 sd=0
XM23 vcmfb_2 vout_2 vtail_cmfb2 vdd pfet_03v3 L=0.84u W=8u nf=2 ad='int((nf+1)/2) * W/nf * 0.18u' as='int((nf+2)/2) * W/nf * 0.18u'
+ pd='2*int((nf+1)/2) * (W/nf + 0.18u)' ps='2*int((nf+2)/2) * (W/nf + 0.18u)' nrd='0.18u / W' nrs='0.18u / W' sa=0 sb=0 sd=0
.ends

.end
